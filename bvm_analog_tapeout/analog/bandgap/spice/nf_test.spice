* does nf multiply W, or divide it?
.lib $PDK_ROOT/sky130A/libs.tech/ngspice/sky130.lib.spice tt
Vdd VDD 0 1.8
Vg  G 0 1.2
X1 D1 G 0 0 sky130_fd_pr__nfet_01v8 L=4 W=40 nf=1 m=1
Vd1 VDD D1 0
X4 D4 G 0 0 sky130_fd_pr__nfet_01v8 L=4 W=40 nf=4 m=1
Vd4 VDD D4 0
.control
op
let i1 = -i(Vd1)*1e6
let i4 = -i(Vd4)*1e6
let ratio = i4/i1
print i1 i4 ratio
quit
.endc
.end
