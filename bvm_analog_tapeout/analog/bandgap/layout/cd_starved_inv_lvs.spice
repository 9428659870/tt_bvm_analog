* NGSPICE file created from cd_starved_inv.ext - technology: sky130A

.subckt cd_n1_l015 B D S G
X0 S G D B sky130_fd_pr__nfet_01v8 ad=0.29 pd=2.58 as=0.29 ps=2.58 w=1 l=0.15
.ends

.subckt cd_p2_l015 B D S G
X0 S G D B sky130_fd_pr__pfet_01v8 ad=0.58 pd=4.58 as=0.58 ps=4.58 w=2 l=0.15
.ends

.subckt cd_p2_l1 B D S G
X0 S G D B sky130_fd_pr__pfet_01v8 ad=0.58 pd=4.58 as=0.58 ps=4.58 w=2 l=1
.ends

.subckt cd_n1_l1 B D S G
X0 S G D B sky130_fd_pr__nfet_01v8 ad=0.29 pd=2.58 as=0.29 ps=2.58 w=1 l=1
.ends

.subckt cd_starved_inv a y vbn VDD VSS
Xu_mn VSS y u_mn/S a cd_n1_l015
Xu_mp VDD y u_mp/S a cd_p2_l015
Xu_mps VDD u_mp/S VDD vbn cd_p2_l1
Xu_mns VSS u_mn/S VSS vbn cd_n1_l1
.ends
