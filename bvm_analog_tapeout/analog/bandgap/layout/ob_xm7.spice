* NGSPICE file created from ob_xm7.ext - technology: sky130A

.subckt ob_p20_l0p5_f4 B D0 G S1 D2 S3 a_287_n500#
X0 S1 G D0 B sky130_fd_pr__pfet_01v8 ad=0.725 pd=5.29 as=1.45 ps=10.58 w=5 l=0.5
X1 a_287_n500# G S3 B sky130_fd_pr__pfet_01v8 ad=1.45 pd=10.58 as=0.725 ps=5.29 w=5 l=0.5
X2 S3 G D2 B sky130_fd_pr__pfet_01v8 ad=0.725 pd=5.29 as=0.725 ps=5.29 w=5 l=0.5
X3 D2 G S1 B sky130_fd_pr__pfet_01v8 ad=0.725 pd=5.29 as=0.725 ps=5.29 w=5 l=0.5
.ends

.subckt ob_xm7 D S G B
Xu_dev B D G S D S D ob_p20_l0p5_f4
.ends
