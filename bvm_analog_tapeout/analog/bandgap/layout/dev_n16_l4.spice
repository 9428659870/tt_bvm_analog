* NGSPICE file created from dev_n16_l4.ext - technology: sky130A

.subckt dev_n16_l4 B D S G
X0 S G D B sky130_fd_pr__nfet_01v8 ad=4.64 pd=32.58 as=4.64 ps=32.58 w=16 l=4
.ends
