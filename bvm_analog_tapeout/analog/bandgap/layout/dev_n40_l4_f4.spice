* NGSPICE file created from dev_n40_l4_f4.ext - technology: sky130A

.subckt dev_n40_l4_f4 D0 G0 S1 G1 D2 G2 S3 G3
X0 S3 G2 D2 VSUBS sky130_fd_pr__nfet_01v8 ad=1.45 pd=10.29 as=1.45 ps=10.29 w=10 l=4
X1 a_1687_n1000# G3 S3 VSUBS sky130_fd_pr__nfet_01v8 ad=2.9 pd=20.58 as=1.45 ps=10.29 w=10 l=4
X2 S1 G0 D0 VSUBS sky130_fd_pr__nfet_01v8 ad=1.45 pd=10.29 as=2.9 ps=20.58 w=10 l=4
X3 D2 G1 S1 VSUBS sky130_fd_pr__nfet_01v8 ad=1.45 pd=10.29 as=1.45 ps=10.29 w=10 l=4
.ends
