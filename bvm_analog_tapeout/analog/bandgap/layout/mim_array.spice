* NGSPICE file created from mim_array.ext - technology: sky130A

.subckt mimcap_unit C2 C1
X0 C1 C2 sky130_fd_pr__cap_mim_m3_1 l=5 w=5
.ends

.subckt mim_array SUM VBE DVBE OTAOUT TRIM8 TRIM4 TRIM2 TRIM1 VSS
Xring_64 VSS VSS mimcap_unit
Xring_86 VSS VSS mimcap_unit
Xring_97 VSS VSS mimcap_unit
Xring_75 VSS VSS mimcap_unit
Xu_T2_r3c1 TRIM2 SUM mimcap_unit
Xu_B_r6c5 DVBE SUM mimcap_unit
Xring_87 VSS VSS mimcap_unit
Xring_65 VSS VSS mimcap_unit
Xring_76 VSS VSS mimcap_unit
Xu_d_r7c7 VSS VSS mimcap_unit
Xring_98 VSS VSS mimcap_unit
Xu_B_r6c6 DVBE SUM mimcap_unit
Xring_99 VSS VSS mimcap_unit
Xring_88 VSS VSS mimcap_unit
Xring_66 VSS VSS mimcap_unit
Xu_B_r2c0 DVBE SUM mimcap_unit
Xring_77 VSS VSS mimcap_unit
Xu_B_r2c1 DVBE SUM mimcap_unit
Xring_89 VSS VSS mimcap_unit
Xring_78 VSS VSS mimcap_unit
Xring_67 VSS VSS mimcap_unit
Xu_T8_r5c2 TRIM8 SUM mimcap_unit
Xring_68 VSS VSS mimcap_unit
Xu_d_r1c0 VSS VSS mimcap_unit
Xring_79 VSS VSS mimcap_unit
Xring_69 VSS VSS mimcap_unit
Xu_B_r4c7 DVBE SUM mimcap_unit
Xu_B_r0c1 DVBE SUM mimcap_unit
Xu_T8_r5c5 TRIM8 SUM mimcap_unit
Xu_T8_r3c2 TRIM8 SUM mimcap_unit
Xu_B_r0c2 DVBE SUM mimcap_unit
Xu_B_r2c6 DVBE SUM mimcap_unit
Xu_B_r0c3 DVBE SUM mimcap_unit
Xu_B_r2c7 DVBE SUM mimcap_unit
Xu_B_r0c4 DVBE SUM mimcap_unit
Xu_F_r5c3 OTAOUT SUM mimcap_unit
Xu_T8_r3c5 TRIM8 SUM mimcap_unit
Xu_B_r0c5 DVBE SUM mimcap_unit
Xu_F_r5c4 OTAOUT SUM mimcap_unit
Xu_d_r1c7 VSS VSS mimcap_unit
Xu_B_r0c6 DVBE SUM mimcap_unit
Xu_B_r7c1 DVBE SUM mimcap_unit
Xu_A_r4c3 VBE SUM mimcap_unit
Xu_d_r6c0 VSS VSS mimcap_unit
Xu_A_r4c4 VBE SUM mimcap_unit
Xu_B_r7c2 DVBE SUM mimcap_unit
Xu_B_r7c3 DVBE SUM mimcap_unit
Xu_B_r5c0 DVBE SUM mimcap_unit
Xu_B_r7c4 DVBE SUM mimcap_unit
Xu_B_r5c1 DVBE SUM mimcap_unit
Xu_T1_r3c6 TRIM1 SUM mimcap_unit
Xu_B_r7c5 DVBE SUM mimcap_unit
Xu_B_r7c6 DVBE SUM mimcap_unit
Xu_d_r4c1 VSS VSS mimcap_unit
Xu_B_r3c0 DVBE SUM mimcap_unit
Xu_T4_r1c3 TRIM4 SUM mimcap_unit
Xu_T4_r1c4 TRIM4 SUM mimcap_unit
Xu_d_r6c7 VSS VSS mimcap_unit
Xu_B_r5c6 DVBE SUM mimcap_unit
Xu_T2_r4c6 TRIM2 SUM mimcap_unit
Xu_B_r5c7 DVBE SUM mimcap_unit
Xu_B_r1c1 DVBE SUM mimcap_unit
Xu_T8_r4c2 TRIM8 SUM mimcap_unit
Xu_d_r0c0 VSS VSS mimcap_unit
Xu_B_r1c2 DVBE SUM mimcap_unit
Xu_B_r3c7 DVBE SUM mimcap_unit
Xu_T8_r4c5 TRIM8 SUM mimcap_unit
Xu_T8_r2c2 TRIM8 SUM mimcap_unit
Xu_B_r1c5 DVBE SUM mimcap_unit
Xu_B_r1c6 DVBE SUM mimcap_unit
Xring_90 VSS VSS mimcap_unit
Xu_T4_r6c3 TRIM4 SUM mimcap_unit
Xu_T8_r2c5 TRIM8 SUM mimcap_unit
Xring_80 VSS VSS mimcap_unit
Xring_91 VSS VSS mimcap_unit
Xu_T4_r6c4 TRIM4 SUM mimcap_unit
Xu_d_r7c0 VSS VSS mimcap_unit
Xu_d_r0c7 VSS VSS mimcap_unit
Xring_92 VSS VSS mimcap_unit
Xring_70 VSS VSS mimcap_unit
Xring_81 VSS VSS mimcap_unit
Xring_82 VSS VSS mimcap_unit
Xring_93 VSS VSS mimcap_unit
Xring_71 VSS VSS mimcap_unit
Xu_A_r3c3 VBE SUM mimcap_unit
Xu_F_r2c3 OTAOUT SUM mimcap_unit
Xu_B_r6c1 DVBE SUM mimcap_unit
Xring_94 VSS VSS mimcap_unit
Xring_72 VSS VSS mimcap_unit
Xring_83 VSS VSS mimcap_unit
Xu_B_r6c2 DVBE SUM mimcap_unit
Xu_A_r3c4 VBE SUM mimcap_unit
Xu_F_r2c4 OTAOUT SUM mimcap_unit
Xring_84 VSS VSS mimcap_unit
Xring_95 VSS VSS mimcap_unit
Xring_73 VSS VSS mimcap_unit
Xu_B_r4c0 DVBE SUM mimcap_unit
Xring_85 VSS VSS mimcap_unit
Xring_74 VSS VSS mimcap_unit
Xring_96 VSS VSS mimcap_unit
.ends
