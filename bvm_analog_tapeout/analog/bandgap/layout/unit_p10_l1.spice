* NGSPICE file created from unit_p10_l1.ext - technology: sky130A

.subckt unit_p10_l1 D S G
X0 S G D w_n194_n1100# sky130_fd_pr__pfet_01v8 ad=2.9 pd=20.58 as=2.9 ps=20.58 w=10 l=1
.ends
