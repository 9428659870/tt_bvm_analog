* NGSPICE file created from bias_gen.ext - technology: sky130A

.subckt bg_n4_l2 D S G VSUBS
X0 S G D VSUBS sky130_fd_pr__nfet_01v8 ad=1.16 pd=8.58 as=1.16 ps=8.58 w=4 l=2
.ends

.subckt bg_sw16 B D0 G S1 D2 S3 D4 S5 D6 S7 D8 S9 D10 S11 D12 S13 D14 S15 a_735_n400#
X0 D6 G S5 B sky130_fd_pr__nfet_01v8 ad=0.66 pd=4.33 as=0.66 ps=4.33 w=4 l=0.15
X1 S13 G D12 B sky130_fd_pr__nfet_01v8 ad=0.66 pd=4.33 as=0.66 ps=4.33 w=4 l=0.15
X2 S3 G D2 B sky130_fd_pr__nfet_01v8 ad=0.66 pd=4.33 as=0.66 ps=4.33 w=4 l=0.15
X3 S9 G D8 B sky130_fd_pr__nfet_01v8 ad=0.66 pd=4.33 as=0.66 ps=4.33 w=4 l=0.15
X4 a_735_n400# G S15 B sky130_fd_pr__nfet_01v8 ad=1.24 pd=8.62 as=0.66 ps=4.33 w=4 l=0.15
X5 S7 G D6 B sky130_fd_pr__nfet_01v8 ad=0.66 pd=4.33 as=0.66 ps=4.33 w=4 l=0.15
X6 D4 G S3 B sky130_fd_pr__nfet_01v8 ad=0.66 pd=4.33 as=0.66 ps=4.33 w=4 l=0.15
X7 S15 G D14 B sky130_fd_pr__nfet_01v8 ad=0.66 pd=4.33 as=0.66 ps=4.33 w=4 l=0.15
X8 S1 G D0 B sky130_fd_pr__nfet_01v8 ad=0.66 pd=4.33 as=1.24 ps=8.62 w=4 l=0.15
X9 D8 G S7 B sky130_fd_pr__nfet_01v8 ad=0.66 pd=4.33 as=0.66 ps=4.33 w=4 l=0.15
X10 D12 G S11 B sky130_fd_pr__nfet_01v8 ad=0.66 pd=4.33 as=0.66 ps=4.33 w=4 l=0.15
X11 D2 G S1 B sky130_fd_pr__nfet_01v8 ad=0.66 pd=4.33 as=0.66 ps=4.33 w=4 l=0.15
X12 S11 G D10 B sky130_fd_pr__nfet_01v8 ad=0.66 pd=4.33 as=0.66 ps=4.33 w=4 l=0.15
X13 S5 G D4 B sky130_fd_pr__nfet_01v8 ad=0.66 pd=4.33 as=0.66 ps=4.33 w=4 l=0.15
X14 D14 G S13 B sky130_fd_pr__nfet_01v8 ad=0.66 pd=4.33 as=0.66 ps=4.33 w=4 l=0.15
X15 D10 G S9 B sky130_fd_pr__nfet_01v8 ad=0.66 pd=4.33 as=0.66 ps=4.33 w=4 l=0.15
.ends

.subckt bg_sw16_w D S G B
Xu_dev B D G S D S D S D S D S D S D S D S D bg_sw16
.ends

.subckt bg_sw1 B D S G
X0 S G D B sky130_fd_pr__nfet_01v8 ad=1.16 pd=8.58 as=1.16 ps=8.58 w=4 l=0.15
.ends

.subckt bg_sw2 B D0 G S1 a_63_n400#
X0 a_63_n400# G S1 B sky130_fd_pr__nfet_01v8 ad=1.24 pd=8.62 as=0.66 ps=4.33 w=4 l=0.15
X1 S1 G D0 B sky130_fd_pr__nfet_01v8 ad=0.66 pd=4.33 as=1.24 ps=8.62 w=4 l=0.15
.ends

.subckt bg_sw2_w D S G B
Xu_dev B D G S D bg_sw2
.ends

.subckt bg_sw4 B D0 G S1 D2 S3 a_159_n400#
X0 S3 G D2 B sky130_fd_pr__nfet_01v8 ad=0.66 pd=4.33 as=0.66 ps=4.33 w=4 l=0.15
X1 S1 G D0 B sky130_fd_pr__nfet_01v8 ad=0.66 pd=4.33 as=1.24 ps=8.62 w=4 l=0.15
X2 D2 G S1 B sky130_fd_pr__nfet_01v8 ad=0.66 pd=4.33 as=0.66 ps=4.33 w=4 l=0.15
X3 a_159_n400# G S3 B sky130_fd_pr__nfet_01v8 ad=1.24 pd=8.62 as=0.66 ps=4.33 w=4 l=0.15
.ends

.subckt bg_sw4_w D S G B
Xu_dev B D G S D S D bg_sw4
.ends

.subckt bg_sw8 B D0 G S1 D2 S3 D4 S5 D6 S7 a_351_n400#
X0 D2 G S1 B sky130_fd_pr__nfet_01v8 ad=0.66 pd=4.33 as=0.66 ps=4.33 w=4 l=0.15
X1 S5 G D4 B sky130_fd_pr__nfet_01v8 ad=0.66 pd=4.33 as=0.66 ps=4.33 w=4 l=0.15
X2 S3 G D2 B sky130_fd_pr__nfet_01v8 ad=0.66 pd=4.33 as=0.66 ps=4.33 w=4 l=0.15
X3 D4 G S3 B sky130_fd_pr__nfet_01v8 ad=0.66 pd=4.33 as=0.66 ps=4.33 w=4 l=0.15
X4 a_351_n400# G S7 B sky130_fd_pr__nfet_01v8 ad=1.24 pd=8.62 as=0.66 ps=4.33 w=4 l=0.15
X5 S7 G D6 B sky130_fd_pr__nfet_01v8 ad=0.66 pd=4.33 as=0.66 ps=4.33 w=4 l=0.15
X6 S1 G D0 B sky130_fd_pr__nfet_01v8 ad=0.66 pd=4.33 as=1.24 ps=8.62 w=4 l=0.15
X7 D6 G S5 B sky130_fd_pr__nfet_01v8 ad=0.66 pd=4.33 as=0.66 ps=4.33 w=4 l=0.15
.ends

.subckt bg_sw8_w D S G B
Xu_dev B D G S D S D S D S D bg_sw8
.ends

.subckt bias_gen nbias_in VSS
Xu30 u30/D VSS nbias_in VSS bg_n4_l2
Xu31 u31/D VSS nbias_in VSS bg_n4_l2
Xu20 u20/D VSS nbias_in VSS bg_n4_l2
Xu_en u_en/D u_en/S u_en/G VSS bg_sw16_w
Xu32 VSS VSS nbias_in VSS bg_n4_l2
Xu21 u21/D VSS nbias_in VSS bg_n4_l2
Xu10 u10/D VSS nbias_in VSS bg_n4_l2
Xu22 u22/D VSS nbias_in VSS bg_n4_l2
Xu11 u11/D VSS nbias_in VSS bg_n4_l2
Xu00 VSS VSS nbias_in VSS bg_n4_l2
Xu23 u23/D VSS nbias_in VSS bg_n4_l2
Xu12 u12/D VSS nbias_in VSS bg_n4_l2
Xu01 u01/D VSS nbias_in VSS bg_n4_l2
Xu24 u24/D VSS nbias_in VSS bg_n4_l2
Xu13 u13/D VSS nbias_in VSS bg_n4_l2
Xu02 u02/D VSS nbias_in VSS bg_n4_l2
Xu25 u25/D VSS nbias_in VSS bg_n4_l2
Xu14 u14/D VSS nbias_in VSS bg_n4_l2
Xu03 u03/D VSS nbias_in VSS bg_n4_l2
Xu26 u26/D VSS nbias_in VSS bg_n4_l2
Xu15 u15/D VSS nbias_in VSS bg_n4_l2
Xu04 u04/D VSS nbias_in VSS bg_n4_l2
Xu27 u27/D VSS nbias_in VSS bg_n4_l2
Xu28 u28/D VSS nbias_in VSS bg_n4_l2
Xu17 u17/D VSS nbias_in VSS bg_n4_l2
Xu16 u16/D VSS nbias_in VSS bg_n4_l2
Xu05 u05/D VSS nbias_in VSS bg_n4_l2
Xu06 u06/D VSS nbias_in VSS bg_n4_l2
Xu29 u29/D VSS nbias_in VSS bg_n4_l2
Xu18 u18/D VSS nbias_in VSS bg_n4_l2
Xu07 u07/D VSS nbias_in VSS bg_n4_l2
Xu19 u19/D VSS nbias_in VSS bg_n4_l2
Xu08 u08/D VSS nbias_in VSS bg_n4_l2
Xu09 u09/D VSS nbias_in VSS bg_n4_l2
Xu_sw0 VSS u_sw0/D u_sw0/S u_sw0/G bg_sw1
Xu_sw1 u_sw1/D u_sw1/S u_sw1/G VSS bg_sw2_w
Xu_sw2 u_sw2/D u_sw2/S u_sw2/G VSS bg_sw4_w
Xu_sw3 u_sw3/D u_sw3/S u_sw3/G VSS bg_sw8_w
Xu_sw4 u_sw4/D u_sw4/S u_sw4/G VSS bg_sw16_w
.ends
