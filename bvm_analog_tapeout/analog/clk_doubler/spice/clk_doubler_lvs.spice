* clk_doubler_lvs.spice -- device level, mirrors analog/bandgap/layout/.
* Generated by gen_clk_doubler.py; edit that, not this.
* Port orders taken from the extraction.

.subckt cd_p2_l015 B D S G
XM0 D G S B sky130_fd_pr__pfet_01v8 L=0.15 W=2 nf=1 m=1
.ends cd_p2_l015
.subckt cd_n1_l015 B D S G
XM0 D G S B sky130_fd_pr__nfet_01v8 L=0.15 W=1 nf=1 m=1
.ends cd_n1_l015
.subckt cd_p4_l015 B D S G
XM0 D G S B sky130_fd_pr__pfet_01v8 L=0.15 W=4 nf=1 m=1
.ends cd_p4_l015
.subckt cd_n4_l015 B D S G
XM0 D G S B sky130_fd_pr__nfet_01v8 L=0.15 W=4 nf=1 m=1
.ends cd_n4_l015
.subckt cd_p8_l015 B D S G
XM0 D G S B sky130_fd_pr__pfet_01v8 L=0.15 W=8 nf=1 m=1
.ends cd_p8_l015
.subckt cd_p2_l1 B D S G
XM0 D G S B sky130_fd_pr__pfet_01v8 L=1 W=2 nf=1 m=1
.ends cd_p2_l1
.subckt cd_n1_l1 B D S G
XM0 D G S B sky130_fd_pr__nfet_01v8 L=1 W=1 nf=1 m=1
.ends cd_n1_l1
.subckt cd_c40f C2 C1
XC0 C1 C2 sky130_fd_pr__cap_mim_m3_1 l=4.29 w=4.29
.ends cd_c40f
.subckt cd_starved_inv y vbn a VDD VSS
Xu_mp VDD y np a cd_p2_l015
Xu_mn VSS y nn a cd_n1_l015
Xu_mps VDD np VDD vbn cd_p2_l1
Xu_mns VSS nn VSS vbn cd_n1_l1
.ends cd_starved_inv
.subckt cd_inv a y VDD VSS
Xu_mp VDD y VDD a cd_p2_l015
Xu_mn VSS y VSS a cd_n1_l015
.ends cd_inv
.subckt cd_obuf a y VDD VSS
Xu_mp VDD y VDD a cd_p8_l015
Xu_mn VSS y VSS a cd_n4_l015
.ends cd_obuf
.subckt cd_nand2 a b VDD VSS y
Xu_g1a VDD y VDD a cd_p4_l015
Xu_g1b VDD y VDD b cd_p4_l015
Xu_g2a VSS y nmid a cd_n4_l015
Xu_g2b VSS nmid VSS b cd_n4_l015
.ends cd_nand2
.subckt cd_tg2 ga gb y sa sb VSS
Xu_tg1a VSS y sa ga cd_n1_l015
Xu_tg1b VSS y sb gb cd_n1_l015
.ends cd_tg2
.subckt clk_doubler clkin clkout en vbias_n VDD VSS
Xu_d1 nd1 vbias_n clkin VDD VSS cd_starved_inv
Xu_d2 nd2 vbias_n nd1 VDD VSS cd_starved_inv
Xu_d3 nd3 vbias_n nd2 VDD VSS cd_starved_inv
Xu_d4 ndly vbias_n nd3 VDD VSS cd_starved_inv
Xu_cd1 VSS nd1 cd_c40f
Xu_cd2 VSS nd2 cd_c40f
Xu_cd3 VSS nd3 cd_c40f
Xu_cd4 VSS ndly cd_c40f
Xu_inv1 clkin nclk VDD VSS cd_inv
Xu_inv2 ndly ndlyb VDD VSS cd_inv
Xu_tg clkin nclk nxor ndly ndlyb VSS cd_tg2
Xu_nand nxor en VDD VSS ngate cd_nand2
Xu_obuf ngate clkout VDD VSS cd_obuf
.ends clk_doubler
