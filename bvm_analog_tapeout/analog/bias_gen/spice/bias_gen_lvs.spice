* bias_gen -- LVS netlist, generated by gen_bias_gen.py.
* Hierarchy and port orders mirror the EXTRACTED layout netlist;
* magic reorders ports per cell, so bg_sw16_w is S G D B while the
* other wrappers are D S G B.

.subckt bg_n4_l2 D S G VSUBS
XM0 D G S VSUBS sky130_fd_pr__nfet_01v8 L=2 W=4 nf=1 m=1
.ends bg_n4_l2

.subckt bg_sw1 B D S G
XM0 D G S B sky130_fd_pr__nfet_01v8 L=0.15 W=4 nf=1 m=1
.ends bg_sw1

.subckt bg_sw2 B D0 G S1 D2
XM0 D0 G S1 B sky130_fd_pr__nfet_01v8 L=0.15 W=4 nf=1 m=1
XM1 S1 G D2 B sky130_fd_pr__nfet_01v8 L=0.15 W=4 nf=1 m=1
.ends bg_sw2

.subckt bg_sw2_w D S G B
Xu_dev B D G S D bg_sw2
.ends bg_sw2_w

.subckt bg_sw4 B D0 G S1 D2 S3 D4
XM0 D0 G S1 B sky130_fd_pr__nfet_01v8 L=0.15 W=4 nf=1 m=1
XM1 S1 G D2 B sky130_fd_pr__nfet_01v8 L=0.15 W=4 nf=1 m=1
XM2 D2 G S3 B sky130_fd_pr__nfet_01v8 L=0.15 W=4 nf=1 m=1
XM3 S3 G D4 B sky130_fd_pr__nfet_01v8 L=0.15 W=4 nf=1 m=1
.ends bg_sw4

.subckt bg_sw4_w D S G B
Xu_dev B D G S D S D bg_sw4
.ends bg_sw4_w

.subckt bg_sw8 B D0 G S1 D2 S3 D4 S5 D6 S7 D8
XM0 D0 G S1 B sky130_fd_pr__nfet_01v8 L=0.15 W=4 nf=1 m=1
XM1 S1 G D2 B sky130_fd_pr__nfet_01v8 L=0.15 W=4 nf=1 m=1
XM2 D2 G S3 B sky130_fd_pr__nfet_01v8 L=0.15 W=4 nf=1 m=1
XM3 S3 G D4 B sky130_fd_pr__nfet_01v8 L=0.15 W=4 nf=1 m=1
XM4 D4 G S5 B sky130_fd_pr__nfet_01v8 L=0.15 W=4 nf=1 m=1
XM5 S5 G D6 B sky130_fd_pr__nfet_01v8 L=0.15 W=4 nf=1 m=1
XM6 D6 G S7 B sky130_fd_pr__nfet_01v8 L=0.15 W=4 nf=1 m=1
XM7 S7 G D8 B sky130_fd_pr__nfet_01v8 L=0.15 W=4 nf=1 m=1
.ends bg_sw8

.subckt bg_sw8_w D S G B
Xu_dev B D G S D S D S D S D bg_sw8
.ends bg_sw8_w

.subckt bg_sw16 B D0 G S1 D2 S3 D4 S5 D6 S7 D8 S9 D10 S11 D12 S13 D14 S15 D16
XM0 D0 G S1 B sky130_fd_pr__nfet_01v8 L=0.15 W=4 nf=1 m=1
XM1 S1 G D2 B sky130_fd_pr__nfet_01v8 L=0.15 W=4 nf=1 m=1
XM2 D2 G S3 B sky130_fd_pr__nfet_01v8 L=0.15 W=4 nf=1 m=1
XM3 S3 G D4 B sky130_fd_pr__nfet_01v8 L=0.15 W=4 nf=1 m=1
XM4 D4 G S5 B sky130_fd_pr__nfet_01v8 L=0.15 W=4 nf=1 m=1
XM5 S5 G D6 B sky130_fd_pr__nfet_01v8 L=0.15 W=4 nf=1 m=1
XM6 D6 G S7 B sky130_fd_pr__nfet_01v8 L=0.15 W=4 nf=1 m=1
XM7 S7 G D8 B sky130_fd_pr__nfet_01v8 L=0.15 W=4 nf=1 m=1
XM8 D8 G S9 B sky130_fd_pr__nfet_01v8 L=0.15 W=4 nf=1 m=1
XM9 S9 G D10 B sky130_fd_pr__nfet_01v8 L=0.15 W=4 nf=1 m=1
XM10 D10 G S11 B sky130_fd_pr__nfet_01v8 L=0.15 W=4 nf=1 m=1
XM11 S11 G D12 B sky130_fd_pr__nfet_01v8 L=0.15 W=4 nf=1 m=1
XM12 D12 G S13 B sky130_fd_pr__nfet_01v8 L=0.15 W=4 nf=1 m=1
XM13 S13 G D14 B sky130_fd_pr__nfet_01v8 L=0.15 W=4 nf=1 m=1
XM14 D14 G S15 B sky130_fd_pr__nfet_01v8 L=0.15 W=4 nf=1 m=1
XM15 S15 G D16 B sky130_fd_pr__nfet_01v8 L=0.15 W=4 nf=1 m=1
.ends bg_sw16

.subckt bg_sw16_w S G D B
Xu_dev B D G S D S D S D S D S D S D S D S D bg_sw16
.ends bg_sw16_w

.subckt bias_gen nbias_in b0 b1 b2 b3 b4 en iout VDD VSS
Xu00 VSS VSS nbias_in VSS bg_n4_l2
Xu01 nd4 VSS nbias_in VSS bg_n4_l2
Xu02 nd4 VSS nbias_in VSS bg_n4_l2
Xu03 nd4 VSS nbias_in VSS bg_n4_l2
Xu04 nd4 VSS nbias_in VSS bg_n4_l2
Xu05 nd4 VSS nbias_in VSS bg_n4_l2
Xu06 nd4 VSS nbias_in VSS bg_n4_l2
Xu07 nd4 VSS nbias_in VSS bg_n4_l2
Xu08 nd4 VSS nbias_in VSS bg_n4_l2
Xu09 nd3 VSS nbias_in VSS bg_n4_l2
Xu10 nd3 VSS nbias_in VSS bg_n4_l2
Xu11 nd3 VSS nbias_in VSS bg_n4_l2
Xu12 nd3 VSS nbias_in VSS bg_n4_l2
Xu13 nd2 VSS nbias_in VSS bg_n4_l2
Xu14 nd2 VSS nbias_in VSS bg_n4_l2
Xu15 nd1 VSS nbias_in VSS bg_n4_l2
Xu16 nd0 VSS nbias_in VSS bg_n4_l2
Xu17 nd1 VSS nbias_in VSS bg_n4_l2
Xu18 nd2 VSS nbias_in VSS bg_n4_l2
Xu19 nd2 VSS nbias_in VSS bg_n4_l2
Xu20 nd3 VSS nbias_in VSS bg_n4_l2
Xu21 nd3 VSS nbias_in VSS bg_n4_l2
Xu22 nd3 VSS nbias_in VSS bg_n4_l2
Xu23 nd3 VSS nbias_in VSS bg_n4_l2
Xu24 nd4 VSS nbias_in VSS bg_n4_l2
Xu25 nd4 VSS nbias_in VSS bg_n4_l2
Xu26 nd4 VSS nbias_in VSS bg_n4_l2
Xu27 nd4 VSS nbias_in VSS bg_n4_l2
Xu28 nd4 VSS nbias_in VSS bg_n4_l2
Xu29 nd4 VSS nbias_in VSS bg_n4_l2
Xu30 nd4 VSS nbias_in VSS bg_n4_l2
Xu31 nd4 VSS nbias_in VSS bg_n4_l2
Xu32 VSS VSS nbias_in VSS bg_n4_l2
Xu_sw0 VSS ncom nd0 b0 bg_sw1
Xu_sw1 ncom nd1 b1 VSS bg_sw2_w
Xu_sw2 ncom nd2 b2 VSS bg_sw4_w
Xu_sw3 ncom nd3 b3 VSS bg_sw8_w
Xu_sw4 nd4 b4 ncom VSS bg_sw16_w
Xu_en  ncom en iout VSS bg_sw16_w
.ends bias_gen
